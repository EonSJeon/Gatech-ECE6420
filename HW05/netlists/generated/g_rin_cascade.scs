// Design: ECE6420_HW5/CG_stage
simulator lang=spectre
include "/nethome/sjeon84/Gatech-ECE6420/HW05/netlists/reference/ade_e.scs"
global 0
parameters temperature=27
include "/tools/designkits/NCSU/FreePDK4514/ncsu_basekit/models/hspice/tran_models/models_nom/NMOS_VTH.inc"

// ECE6420_HW5/CG_stage/schematic
M4 (net10 net10 0 0) NMOS_VTH w=1uM l=50n ld=105n ls=105n m=1
M3 (VinNode net10 0 0) NMOS_VTH w=10u l=50n ld=105n ls=105n m=1
M1 (Vout net2 VinNode 0) NMOS_VTH w=50.54906934u l=50n ld=105n ls=105n m=1

V0 (net2 0) vsource dc=1 type=dc
I1 (net2 net10) isource dc=100u type=dc
C3 (Vout 0) capacitor c=5.72219665694e-14
C2 (net2 0) capacitor c=5.72219665694e-14
C0 (net10 0) capacitor c=100f
L1 (net2 Vout) inductor l=5.72219665694e-09
RP (net2 Vout) resistor r=1668.24805893

// ===========================================================
// Fig.3 second stage replacing the dummy M2 of Fig.1
// ===========================================================

M5 (Vout2 Vout S2 0) NMOS_VTH w=5u l=50n ld=105n ls=105n m=1

IB2 (S2 0) isource dc=1.5m
CS2 (S2 0) capacitor c=100f

L2 (net2 Vout2) inductor l=3.83056640625e-09
RP2 (net2 Vout2) resistor r=1116.76255727
CP2A (net2 0) capacitor c=3.83056640625e-14
CP2B (Vout2 0) capacitor c=3.83056640625e-14
CLOAD2 (Vout2 0) capacitor c=150f

// ===========================================================
// Two-tone source for the whole cascade
// ===========================================================

// ===========================================================
// HW5(g): small-signal input-impedance test
// 1-A AC current is injected INTO VinNode.
// Thus Zin = V(VinNode) / 1 A = V(VinNode).
// No 50-ohm source/termination is present during this test.
// ===========================================================

ITEST_G (0 VinNode) isource dc=0 type=sine mag=1 phase=0

simulatorOptions options temp=27 reltol=1e-5

ac ac start=4G stop=8G lin=401

save VinNode Vout Vout2 S2
