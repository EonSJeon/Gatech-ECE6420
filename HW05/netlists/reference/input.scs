// Design: ECE6420_HW5/CG_stage
simulator lang=spectre
global 0
parameters temperature=27
include "/tools/designkits/NCSU/FreePDK4514/ncsu_basekit/models/hspice/tran_models/models_nom/NMOS_VTH.inc"

// ECE6420_HW5/CG_stage/schematic
M4 (net10 net10 0 0) NMOS_VTH w=1uM l=50n ld=105n ls=105n m=1
M3 (VinNode net10 0 0) NMOS_VTH w=10u l=50n ld=105n ls=105n m=1
M1 (Vout net2 VinNode 0) NMOS_VTH w=100.0000u l=50n ld=105n ls=105n m=1
M2 (net2 Vout 0 0) NMOS_VTH w=5uM l=50n ld=105n ls=105n m=1
V0 (net2 0) vsource dc=1 type=dc
I1 (net2 net10) isource dc=100u type=dc
C3 (Vout 0) capacitor c=49.9f
C2 (net2 0) capacitor c=49.9f
C0 (net10 0) capacitor c=100f
L1 (net2 Vout) inductor l=4.99n
RP (net2 Vout) resistor r=1.455K
I18 (Vout 0) isource dc=0 type=sine mag=0 phase=0
I15 (0 VinNode) isource dc=0 type=sine mag=1 phase=0
simulatorOptions options temp=27
ac ac start=4G stop=8G lin=401
dcOp dc
save Vout VinNode
